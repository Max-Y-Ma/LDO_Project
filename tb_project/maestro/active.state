ADE simulation setup
Test ece483_sp25_tb_project_1: ece483_sp25/tb_project/schematic, simulator spectre
  Models: /class/ece483/models/models_ece483
  Variables: Cout = 200p; Iload = 20m; Rf1 = 1k; Rf2 = 2k; VIN = 1.8; vin = 1; VREF = 0.8
  Temperature: 27
  Analysis stb: start=1 stop=10G dec=101 probe=/STB_PRB stbProbeMode=differential localgnd=/VSS
  Analysis dc: (saves the operating point)
  Analysis tran: stop=20u errpreset=moderate
  Output Loop Gain Phase = phaseDegUnwrapped(getData("loopGain" ?result "stb")) (unticked)
  Output Loop Gain dB20 = db(mag(getData("loopGain" ?result "stb"))) (unticked)
  Output Phase Margin = getData("phaseMargin" ?result "stb_margin") (unticked)
  Output Gain Margin = getData("gainMargin" ?result "stb_margin") (unticked)
  Output Vout_tran = VT("/Vout") (unticked)
  Output Vin_tran = VT("/Vin") (unticked)
  Output ILoad_tran = IT("/Rload/PLUS") (unticked)
  Output OP("/ECE483_LDO/P0" "region") (unticked)
  Output OP("/ECE483_LDO/P0" "vds") (unticked)
  Output OP("/ECE483_LDO/P0" "vgs") (unticked)
  Output OP("/ECE483_LDO/P0" "ids") (unticked)
  Output VDC("/Vout")
  Signals: /Rload/PLUS (terminal)
Run mode: Single Run, Sweeps and Corners
Specs:
  ece483_sp25_tb_project_1 / Phase Margin: > 60
Setup values for test ece483_sp25_tb_project_1: VIN = 1.62:0.01:1.98
