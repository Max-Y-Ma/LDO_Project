ADE simulation setup
Run mode: Single Run, Sweeps and Corners
Tests:
  ece483_sp25_tb_project_1: ece483_sp25/tb_project/schematic, simulator spectre
    Variables: Cout = 200p; Iload = 20m; Rf1 = 1k; Rf2 = 2k; VIN = 1.62:0.01:1.98; vin = 1; VREF = 0.8
    Outputs: Loop Gain Phase; Loop Gain dB20; Phase Margin; Gain Margin; Vout_tran; Vin_tran
Specs:
  ece483_sp25_tb_project_1 / Phase Margin: > 60
