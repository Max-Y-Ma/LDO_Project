ADE simulation setup
Run mode: Single Run, Sweeps and Corners
Tests:
  ece483_sp23_ldo_model_1: ece483_sp25/ldo_model/schematic, simulator spectre
    Variables: Aea = 3131; Co1 = 1p; Cout = 200p; Gm1 = 605u; Iload = 10m; Lp = 360n; Wp = 2u:1u:10u; Rf1 = 1k; Rf2 = 2k; VIN = 1.8; vin = 0; VREF = 1.2*(Rf2/(Rf1+Rf2)); vref = 0
    Outputs: Vout_tran; rdsp; gmp; region pmos; VDC("/Vg"); Vin_tran
Specs:
  ece483_sp23_ldo_model_1 / Phase Margin: > 60
