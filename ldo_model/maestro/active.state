ADE simulation setup
Test ece483_sp23_ldo_model_1: ece483_sp25/ldo_model/schematic, simulator spectre
  Models: /class/ece483/models/models_ece483
  Variables: Aea = 2000; Co1 = 1p; Cout = 200p; Gm1 = 488u; Iload = 20m; Lp = 360n; Wp = 10u; Rf1 = 1k; Rf2 = 2k; VIN = 1.8; vin = 0; vref = 0; VREF = 0.8
  Temperature: 27
  Analysis dc: (saves the operating point)
  Analysis tran: stop=20u
  Analysis stb: start=1 stop=10G dec=101 probe=/V6 stbProbeMode=differential localgnd=/net7
  Output Loop Gain Phase = phaseDegUnwrapped(getData("loopGain" ?result "stb"))
  Output Loop Gain dB20 = db(mag(getData("loopGain" ?result "stb")))
  Output Phase Margin = getData("phaseMargin" ?result "stb_margin")
  Output Gain Margin = getData("gainMargin" ?result "stb_margin")
  Output Vout_tran = VT("/Vout")
  Output Vin_tran = VT("/Vin")
  Output rdsp = (1 / OP("/P1" "gds"))
  Output gmp = OP("/P1" "gm")
  Output region pmos = OP("/P1" "region")
  Output VDC("/Vout")
  Output IT("/R5/PLUS")
  Signals: /R5/PLUS (terminal)
Run mode: Single Run, Sweeps and Corners
Specs:
  ece483_sp23_ldo_model_1 / Phase Margin: > 60
Setup values for test ece483_sp23_ldo_model_1: Aea = 3131; Gm1 = 605u; Iload = 10m; Wp = 2u:1u:10u; VREF = 1.2*(Rf2/(Rf1+Rf2))
