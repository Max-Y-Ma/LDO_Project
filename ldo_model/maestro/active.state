ADE simulation setup
Test ece483_sp23_ldo_model_1: ece483_sp25/ldo_model/schematic, simulator spectre
  Models: /class/ece483/models/models_ece483
  Variables: Aea = 4000; Co1 = 1p; Cout = 200p; Gm1 = 531u; Iload = 20m; Lp = 360n; Wp = 5.4u; Rf1 = 2k; Rf2 = 1k; VIN = 1.8; vin = 0; vref = 0; VREF = 1.2*(Rf2/(Rf1+Rf2))
  Temperature: 27
  Analysis stb: start=1 stop=10G dec=101 probe=/VSTB stbProbeMode=differential localgnd=/net1
  Analysis dc: (saves the operating point)
  Analysis tran: stop=20u
  Output Loop Gain Phase = phaseDegUnwrapped(getData("loopGain" ?result "stb"))
  Output Loop Gain dB20 = db(mag(getData("loopGain" ?result "stb")))
  Output Phase Margin = getData("phaseMargin" ?result "stb_margin")
  Output Gain Margin = getData("gainMargin" ?result "stb_margin") (unticked)
  Output Vout_tran = VT("/Vout") (unticked)
  Output Vin_tran = VT("/Vin") (unticked)
  Output rdsp = (1 / OP("/P0" "gds")) (unticked)
  Output gmp = OP("/P0" "gm")
  Output region pmos = OP("/P0" "region") (unticked)
  Output VDC("/Vout")
  Output VDC("/Vg") (unticked)
  Output IT("/I4/PLUS") (unticked)
  Signals: /I4/PLUS (terminal)
Run mode: Single Run, Sweeps and Corners
Specs:
  ece483_sp23_ldo_model_1 / Phase Margin: > 60
Setup values for test ece483_sp23_ldo_model_1: Aea = 3131; Gm1 = 605u; Iload = 10m; Wp = 2u:1u:10u; Rf1 = 1k; Rf2 = 2k
